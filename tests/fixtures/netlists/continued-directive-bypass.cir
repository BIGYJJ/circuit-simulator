.model DLED D(IS=1e-12)
+ .shell touch owned
