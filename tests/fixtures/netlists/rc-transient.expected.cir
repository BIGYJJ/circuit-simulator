* FLUXLAB GENERATED NETLIST
C1 N0001 0 0.0001
R1 N0002 N0001 10000
V1 N0002 0 DC 0 PULSE(0 5 0 1e-9 1e-9 10 20)
.save time v(N0001)
.tran 0.01 5
.end
