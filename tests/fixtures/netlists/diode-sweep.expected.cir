FLUXLAB GENERATED NETLIST
.include "model-a4554d8c891cff561a2833915ef6bb96d3f324ab31ce68600931a61b8b867d59.lib"
D1 N0001 0 DMOD AREA=1
V1 N0001 0 DC 0
.save @d1[p] v1
.dc V1 0.4 0.8 0.01
.end
