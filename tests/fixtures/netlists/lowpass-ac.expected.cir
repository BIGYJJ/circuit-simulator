FLUXLAB GENERATED NETLIST
C1 N0001 0 0.000001
R1 N0002 N0001 1000
V1 N0002 0 DC 0 AC 1 0
.save frequency v(N0001)
.ac dec 20 1 100000
.end
