* FLUXLAB GENERATED NETLIST
R1 N0001 VOUT 1000
R2 VOUT 0 2000
V1 N0001 0 DC 9
.save v(VOUT)
.op
.end
