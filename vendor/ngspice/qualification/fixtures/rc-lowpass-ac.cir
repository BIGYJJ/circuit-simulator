* RC lowpass
V1 1 0 DC 0 AC 1
R1 1 2 1k
C1 2 0 1u
.save v(2) @r1[i] @c1[i]
.ac dec 20 1 1e5
.end
