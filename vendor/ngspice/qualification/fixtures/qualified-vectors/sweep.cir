* qualified vector sweep
V1 1 0 DC 0
R1 1 2 1k
R2 2 0 1k
D1 1 0 DMOD
.model DMOD D
.save @v1[i] @r1[i] @r1[p] @d1[p]
.dc V1 0.2 1 0.1
.end
